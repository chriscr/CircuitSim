* Simple forward-biased Shockley diode operating point
V1 in 0 DC 5
R1 in out 1k
D1 out 0
.END
