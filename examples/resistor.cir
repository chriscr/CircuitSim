* 5 V source and 1 kohm resistor: current magnitude = 5 mA
V1 in 0 DC 5
R1 in 0 1k
.END
